// Design: lab4/lab4_testbench
simulator lang=spectre
global 0
parameters temperature=27 Vbias=1.4 vdd=2.5
include "/opt/cadence-designkits/gpdk045_v_6_0/gpdk045/../models/spectre/gpdk045.scs" section=mc

// lab4/lab4_v1/schematic
subckt lab4_v1 Ibias gnd in\+ in\- out vdd
    NM11 (net16 net15 gnd gnd) g45n1svt w=(240n) l=160n nf=1 m=(20)
    NM12 (net15 net15 gnd gnd) g45n1svt w=(240n) l=160n nf=1 m=(1)
    NM6 (net6 in\+ net16 gnd) g45n1svt w=(8.64u) l=1.92u nf=1 m=(10)
    NM7 (net8 in\- net16 gnd) g45n1svt w=(8.64u) l=1.92u nf=1 m=(10)
    NM9 (CMID net1 net6 gnd) g45n1svt w=(8.64u) l=1.92u nf=1 m=(10)
    NM8 (net2 net1 net8 gnd) g45n1svt w=(8.64u) l=1.92u nf=1 m=(10)
    NM13 (out net15 gnd gnd) g45n1svt w=(1.92u) l=1.28u nf=1 m=(80)
    C_MILLER (CMID NCOMP) capacitor c=6p
    R_ZERO (NCOMP out) resistor r=125
    R18 (net15 net1) resistor r=190K
    R15 (Ibias net3) resistor r=10K
    PM4 (net1 net3 vdd vdd) g45p1svt w=(280n) l=160n nf=1 m=(1)
    PM5 (net3 net3 vdd vdd) g45p1svt w=(280n) l=160n nf=1 m=(1)
    PM3 (S net2 vdd vdd) g45p1svt w=(10u) l=1.92u nf=1 m=(10)
    PM2 (CMID Ibias S vdd) g45p1svt w=(10u) l=1.92u nf=1 m=(10)
    PM1 (net14 net2 vdd vdd) g45p1svt w=(10u) l=1.92u nf=1 m=(10)
    PM0 (net2 Ibias net14 vdd) g45p1svt w=(10u) l=1.92u nf=1 m=(10)
    PM6 (out CMID vdd vdd) g45p1svt w=(6.72u) l=1.28u nf=1 m=(80)
ends lab4_v1

// lab4/lab4_testbench/schematic
V0 (in\+ 0) vsource dc=Vbias mag=1 type=sine
V1 (net1 0) vsource dc=vdd type=dc
V3 (net4 0) vsource dc=vdd type=dc
I7 (net6 0) isource dc=10u type=dc
E2 (in\- 0 net2 0) vcvs gain=1.0
E1 (net10 0 out 0) vcvs gain=1.0
I9 (net6 0 in\+ in\- out net4) lab4_v1
C0 (out 0) capacitor c=1p
C1 (net2 0) capacitor c=1
R3 (net5 net3) resistor r=9K
R2 (0 net3) resistor r=2.401K
R1 (net3 net1) resistor r=1.715K
R0 (net2 net10) resistor r=1M
simulatorOptions options temp=27
ac ac start=1 stop=10G dec=1000
dcOp dc
save out
saveOptions options save=all pwr=none currents=all
