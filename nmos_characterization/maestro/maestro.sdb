ADE simulation setup
Run mode: Single Run, Sweeps and Corners
Tests:
  lab3_nmos_characterization_1: lab4/nmos_characterization/schematic, simulator spectre
