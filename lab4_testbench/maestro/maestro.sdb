ADE simulation setup
Run mode: Single Run, Sweeps and Corners
Tests:
  ECE4530_2026_MP2_test_bench_1: lab4/lab4_testbench/schematic, simulator spectre
    Variables: Vbias = 1.4; vdd = 2.5
    Outputs: ((OutP + OutN) / 2); (20 * log10(((OutP + OutN) / 2))); (20 * log10(((vfreq('ac "/out_p") + vfreq('ac "/out_n")) / 2))); (db(((OutP + OutN) / 2))); db20(VF("/out")); VDC("/out'))) "); VDC("/out "); VDC("/out"); VDC("/in+)) "); VDC("/in+"); VDC("/in-"); VT("/out"); deriv(v("/out" ?result "dc")); dB20(VF("/out")); phase(VF("/out"))
Global variables:
  acm_cm = 0
  acm_in = 1
  acm_vdd = 0
  iout = 0
