ADE simulation setup
Run mode: Single Run, Sweeps and Corners
Tests:
  ECE4530_2026_MP2_test_bench_1: lab4/lab4_testbench/schematic, simulator spectre
    Variables: AC_CM = 1; AC_DM = 0; F1 = 1M; F2 = 500M; Vbias = 1.4; vdd = 2.4
    Outputs: ((OutP + OutN) / 2); (20 * log10(((OutP + OutN) / 2))); (20 * log10(((vfreq('ac "/out_p") + vfreq('ac "/out_n")) / 2))); (db(((OutP + OutN) / 2))); AvCMAC; PhaseDMAC
