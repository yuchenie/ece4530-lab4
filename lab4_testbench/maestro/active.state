ADE simulation setup
Test ECE4530_2026_MP2_test_bench_1: lab4/lab4_testbench/schematic, simulator spectre
  Models: /opt/cadence-designkits/gpdk045_v_6_0/gpdk045/../models/spectre/gpdk045.scs[mc]
  Variables: Vbias = 1.4; vdd = 2.5
  Temperature: 27
  Analysis ac: start=1 stop=10G dec=1000
  Output db20(VF("/out")) (unticked)
  Output VDC("/out") (unticked)
  Output VDC("/in+") (unticked)
  Output VDC("/in-") (unticked)
  Output VT("/out") (unticked)
  Output deriv(v("/out" ?result "dc")) (unticked)
  Output dB20(VF("/out"))
  Output phase(VF("/out"))
  Signals: /out, /in+
Run mode: Single Run, Sweeps and Corners
