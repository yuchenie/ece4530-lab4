ADE simulation setup
Test ECE4530_2026_MP2_test_bench_1: lab4/lab4_testbench/schematic, simulator spectre
  Models: /opt/cadence-designkits/gpdk045_v_6_0/gpdk045/../models/spectre/gpdk045.scs[mc]
  Variables: Vbias = 1.4; vdd = 2.4
  Temperature: 27
  Analysis dc: (saves the operating point)
  Analysis tran: stop=5u errpreset=moderate
  Analysis ac: start=10k stop=1G dec=1000
Run mode: Single Run, Sweeps and Corners
Setup values for test ECE4530_2026_MP2_test_bench_1: vdd = 2.5
