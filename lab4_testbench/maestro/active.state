ADE simulation setup
Test ECE4530_2026_MP2_test_bench_1: lab4/lab4_testbench/schematic, simulator spectre
  Models: /opt/cadence-designkits/gpdk045_v_6_0/gpdk045/../models/spectre/gpdk045.scs[mc]
  Variables: Vbias = 1.4; vdd = 2.5
  Temperature: 27
  Analysis dc: sweep /V0.dc start=1.2 stop=1.6 step=2m (saves the operating point)
  Output db20(VF("/out")) (unticked)
  Output VDC("/out")
  Output VDC("/in+") (unticked)
  Output VDC("/in-") (unticked)
  Output VT("/out") (unticked)
  Output deriv(v("/out" ?result "dc"))
  Signals: /out, /in+, /in-
Run mode: Single Run, Sweeps and Corners
