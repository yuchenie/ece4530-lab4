ADE simulation setup
Test ECE4530_2026_MP2_test_bench_1: lab4/lab4_testbench/schematic, simulator spectre
  Models: /opt/cadence-designkits/gpdk045_v_6_0/gpdk045/../models/spectre/gpdk045.scs[mc]
  Variables: Vbias = 1.4; vdd = 2.5
  Temperature: 27
  Analysis dc: (saves the operating point)
  Analysis ac: start=1 stop=10G dec=1000
  Output db20(VF("/out"))
  Signals: /out
Run mode: Single Run, Sweeps and Corners
