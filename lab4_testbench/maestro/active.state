ADE simulation setup
Test ECE4530_2026_MP2_test_bench_1: lab4/lab4_testbench/schematic, simulator spectre
  Models: /opt/cadence-designkits/gpdk045_v_6_0/gpdk045/../models/spectre/gpdk045.scs[mc]
  Variables: AC_CM = 1; AC_DM = 0; F1 = 1M; F2 = 500M; Vbias = 1.4; vdd = 2.4
  Temperature: 27
  Analysis dc: (saves the operating point)
  Analysis tran: stop=5u errpreset=moderate
  Analysis ac: start=10k stop=1G dec=1000
  Output AvDMAC = db((vfreq('ac "/out_p") - vfreq('ac "/out_n"))) (unticked)
  Output v /out_p; ac dB20(V) = db(vfreq('ac "/out_p")) (unticked)
  Output v /out_n; ac dB20(V) = db(vfreq('ac "/out_n")) (unticked)
  Output PhaseDMAC = phaseDeg((vfreq('ac "/out_p") - vfreq('ac "/out_n"))) (unticked)
  Output AvCMAC = dB20(((vfreq('ac "/out_p") + vfreq('ac "/out_n")) / 2)) (unticked)
Run mode: Single Run, Sweeps and Corners
Setup values for test ECE4530_2026_MP2_test_bench_1: vdd = 2.5
